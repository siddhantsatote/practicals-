* EXP 9 - 5-STAGE CMOS RING OSCILLATOR (LTspice version) - File > Open, then Run
.model NMOD NMOS(Kp=100u Vto=0.5 Lambda=0.05 Cgdo=3e-10 Cgso=3e-10)
.model PMOD PMOS(Kp=50u Vto=-0.5 Lambda=0.05 Cgdo=3e-10 Cgso=3e-10)
VDD vdd 0 1.8
MP1 n2 n1 vdd vdd PMOD W=2u L=0.18u
MN1 n2 n1 0   0   NMOD W=1u L=0.18u
MP2 n3 n2 vdd vdd PMOD W=2u L=0.18u
MN2 n3 n2 0   0   NMOD W=1u L=0.18u
MP3 n4 n3 vdd vdd PMOD W=2u L=0.18u
MN3 n4 n3 0   0   NMOD W=1u L=0.18u
MP4 n5 n4 vdd vdd PMOD W=2u L=0.18u
MN4 n5 n4 0   0   NMOD W=1u L=0.18u
MP5 n1 n5 vdd vdd PMOD W=2u L=0.18u
MN5 n1 n5 0   0   NMOD W=1u L=0.18u
Cl1 n1 0 20f
Cl2 n2 0 20f
Cl3 n3 0 20f
Cl4 n4 0 20f
Cl5 n5 0 20f
.ic V(n1)=0
.tran 20n
.end
