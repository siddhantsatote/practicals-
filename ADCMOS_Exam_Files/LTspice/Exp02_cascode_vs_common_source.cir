* EXP 2 - COMMON SOURCE (left) vs CASCODE (right)  - LTspice: File > Open, then Run
* Lab model: delete .model line, add ".lib AP9465GEM.lib", replace NMOD with the model name.
.model NMOD NMOS(Kp=0.2 Vto=1.5 Lambda=0.02 Cgdo=3e-7 Cgso=3e-7)
* ---- common source ----
VDD1 vdd1 0 12
RD1  vdd1 vo_cs 100
VB3  gcs x1 1.8
Vin1 x1 0 0 AC 1
Rs1  gcs g1 1k
M1   vo_cs g1 0 0 NMOD W=10u L=1u
* ---- cascode ----
VDD2 vdd2 0 15
RD   vdd2 vo_cascode 100
VB1  gc x2 1.8
Vin  x2 0 0 AC 1
Rs2  gc g2 1k
VB2  gcg 0 3.5
MCG  vo_cascode gcg mid 0 NMOD W=10u L=1u
MCS  mid g2 0 0 NMOD W=10u L=1u
.ac dec 100 1 100meg
.end
