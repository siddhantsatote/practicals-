* EXP 1 - COMMON SOURCE AMPLIFIER  (open in LTspice: File > Open, then click Run)
* Generic MOSFET model used so the file runs anywhere.
* To use the lab model instead: delete the .model line below, add ".lib AP9465GEM.lib"
* and change NMOD in the M1 line to the model name inside that file.
.model NMOD NMOS(Kp=0.2 Vto=1.5 Lambda=0.02 Cgdo=3e-7 Cgso=3e-7)
VDD vdd 0 12
RD  vdd vo_cs 100
* gate = VGG(+) ; Vin1 in series below VGG
VGG2 vin_cs x 1.8
Vin1 x 0 0 AC 1
* source resistance so the bandwidth (Miller effect) is visible in the plot
Rs  vin_cs g 1k
M1  vo_cs g 0 0 NMOD W=10u L=1u
.ac dec 10 1 100meg
.end
